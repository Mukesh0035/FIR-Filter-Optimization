ADE simulation setup
Run mode: Single Run, Sweeps and Corners
Tests:
  Practice:6TSRAM:1: Practice/6TSRAM/schematic, simulator spectre
Global variables:
  vdd = 1.8
Corners:
  model folders: /home/buet/cadence/gpdk090_v4.6/models/spectre
  C0v: vdd=1.8, 1; gpdk090.scs[ff, fs, ss, sf]
