simulator( 'spectre )
design(	 "/home/buet/simulation/6TSRAM/spectre/schematic/netlist/netlist")
resultsDir( "/home/buet/simulation/6TSRAM/spectre/schematic" )
modelFile(
    '("/home/buet/cadence/gpdk090_v4.6/libs.oa22/gpdk090/../../models/spectre/gpdk090.scs" "NN")
)
analysis('dc ?saveOppoint t  ?dev "/V5"  ?param "dc"
		?start "0"  ?stop "1.8"  )
envOption(
	'analysisOrder  list("dc")
)
temp( 27 )
run()
selectResult( 'dc )
plot(getData("/q") getData("/qb") )
