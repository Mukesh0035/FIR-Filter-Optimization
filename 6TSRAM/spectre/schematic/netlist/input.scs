// Design: Practice/6TSRAM
simulator lang=spectre
global 0
include "/home/buet/cadence/gpdk090_v4.6/libs.oa22/gpdk090/../../models/spectre/gpdk090.scs" section=NN

// Practice/6TSRAM/schematic
PM1 (q qb net9 net9) gpdk090_pmos1v w=(120n) l=100n m=(1)*(1) simM=(1)*(1)
PM0 (qb q net9 net9) gpdk090_pmos1v w=(120n) l=100n m=(1)*(1) simM=(1)*(1)
NM4 (qb WL Bit_line_bar 0) gpdk090_nmos1v w=(120n) l=100n m=(1)*(1) simM=(1)*(1)
NM5 (Bit_line WL q 0) gpdk090_nmos1v w=(120n) l=100n m=(1)*(1) simM=(1)*(1)
NM1 (q qb 0 0) gpdk090_nmos1v w=(120n) l=100n m=(1)*(1) simM=(1)*(1)
NM0 (qb q 0 0) gpdk090_nmos1v w=(120n) l=100n m=(1)*(1) simM=(1)*(1)
V3 (WL 0) vsource type=pulse val0=0 val1=1.8 period=4u
V1 (Bit_line_bar 0) vsource type=pulse val0=1.8 val1=0 period=2u
V2 (Bit_line 0) vsource type=pulse val0=0 val1=1.8V period=2u
V5 (qb 0) vsource dc=1.8 type=dc
V0 (net9 0) vsource dc=1.8 type=dc
simulatorOptions options temp=27
dcOp dc
dc dc dev=V5 param=dc start=0 stop=1.8
